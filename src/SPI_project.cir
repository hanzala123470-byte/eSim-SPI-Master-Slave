* C:\FOSSEE\eSim-Workspace\SPI_project\SPI_project.cir

* EESchema Netlist Version 1.1 (Spice format) creation date: 01/30/26 19:30:20

* To exclude a component from the Spice Netlist add [Spice_Netlist_Enabled] user FIELD set to: N
* To reorder the component spice node sequence add [Spice_Node_Sequence] user FIELD and define sequence: 2,1,0

* Sheet Name: /
U1  Net-_U1-Pad1_ Net-_U1-Pad2_ Net-_U1-Pad3_ Net-_U1-Pad10_ Net-_U1-Pad11_ Net-_U1-Pad10_ Net-_U1-Pad11_ Net-_U1-Pad10_ Net-_U1-Pad11_ Net-_U1-Pad10_ Net-_U1-Pad11_ Net-_U1-Pad12_ Net-_U1-Pad13_ Net-_U1-Pad14_ Net-_U1-Pad15_ ? spi_master
U7  Net-_U1-Pad14_ Net-_U1-Pad15_ Net-_U1-Pad13_ Net-_U1-Pad12_ ? ? ? ? ? ? ? ? spi_slave
v2  Net-_U4-Pad1_ GND pulse
v3  Net-_U5-Pad1_ GND pulse
v4  Net-_U6-Pad1_ GND pulse
U4  Net-_U4-Pad1_ Net-_U1-Pad1_ adc_bridge_1
U5  Net-_U5-Pad1_ Net-_U1-Pad2_ adc_bridge_1
U6  Net-_U6-Pad1_ Net-_U1-Pad3_ adc_bridge_1
U2  Net-_U2-Pad1_ Net-_U1-Pad10_ adc_bridge_1
v1  Net-_U2-Pad1_ GND 5V
U3  GND Net-_U1-Pad11_ adc_bridge_1

.end
